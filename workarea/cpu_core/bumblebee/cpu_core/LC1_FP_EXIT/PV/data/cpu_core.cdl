* Test mode CDL netlist - Wed Oct 28 14:30:21 IST 2026
.SUBCKT cpu_core
.ENDS cpu_core
